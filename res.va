/* Authors: Andreas Froese, Felix Salfelder
 * Note: too trivial to state License/Copyright
 *
 * Resistor
 */
`define P(x) (*x*)
`include "discipline.h"

module res (p,n);
   inout p,n;
   electrical p,n;

   parameter real R1=10000 from (0:inf)
                  `P(info="Resistor [Ohm]");

   real voltage `P(ask="yes"), current `P(ask="yes"), g;

   analog begin
		@(initial_model) begin
			g=1/R1;
		end

      begin
		   voltage = V(p,n);
         current = voltage*g;
      end

      begin
         I(p,n) <+ current;
      end
   end
endmodule
