// subckt coil connected to internal node.

`include "discipline.h"
`include "gnucap-adms.h"

module subcoil(p,n);
   inout p,n;
   electrical p,n,p1;

   // Model parameters
   parameter real r0=10000 from (0:inf)
                  (*info="Fresh resistance [Ohm]"*);

   real v1, i1, g;
	real a (*ask="yes"*);
	real b (*ask="yes"*);

	branch (p1,p) res;

	L #(.l(1)) l1(p1,n);

   analog begin
		I(res) <+ V(res);
   end
endmodule
