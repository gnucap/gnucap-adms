/* this file is part of gnucap-adms
 *
 * Author: (c) 2013 Felix Salfelder
 * License: GPLv3+
 */

// mul

`include "discipline.h"
`include "constants.h"

module mul(p,a,b);
	inout p,a,b;
	electrical p,a,b;

	parameter real gain = 1 from [0:inf);

	analog begin
		V(p) <+ gain * V(a) * V(b);
   end
endmodule
