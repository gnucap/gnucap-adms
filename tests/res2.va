// Copyright 2013 Felix
// resistor

`include "discipline.h"
`include "constants.h"

module res2(p,n);
	inout p,n;
	electrical p,n;

	parameter real R = 100;

	real v (*ask="yes"*);
	analog begin
		v = V(n,p);
 		I(p,n) <+ v / R * 1;
 		I(n,p) <+ v / R * 2;
   end
endmodule
