// a debugging coil

`include "discipline.h"
`include "constants.h"

module coil_br(p,n);
   inout p,n;
   electrical p,n;
   electrical e1;

   parameter real inductance = 1;
   real i (*ask="yes"*);
   real v (*ask="yes"*);

   analog begin
      i = I(e1,n);
      v = ddt(inductance * I(e1,n));
      V(p,e1) <+ ddt(inductance * I(e1,n));
   // I(p) <+ 0*V(n); // BUG
   end
endmodule
