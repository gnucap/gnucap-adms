// Copyright 2015 Felix
//
// simple voltage source purely for debugging

`include "discipline.h"
`include "constants.h"

module vavs(p,n);
	inout p,n;
	electrical p,n;
	analog begin
		V(p,n) <+ 5;
   end
endmodule
