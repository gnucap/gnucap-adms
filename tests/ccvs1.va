// Copyright 2015 Felix Salfelder
// voltage sources

`include "discipline.h"
`include "constants.h"

module ccvsva(a,b,p,n,cp,cn,x,y);
	inout a,b,p,n,cp,cn,x,y;
	electrical a,b,p,n,cp,cn,x,y;

	parameter real gain    = 1 from [0:inf);
	parameter real offset  = 0;

	analog begin
		V(p,n) <+ I(cp,cn);
		V(p,n) <+ I(cp,cn);
		V(p,n) <+ I(x,y);
		V(a,b) <+ I(x,y);
   end
endmodule
