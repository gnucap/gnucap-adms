/* this file is part of gnucap-adms
 *
 * Author: (c) 2013 Felix Salfelder
 * License: GPLv3+
 */
//
// integrator

`include "discipline.h"
`include "constants.h"

module integrator(p,n,cp,cn);
	inout p,n,cp,cn;
	electrical p,n,cp,cn;

	parameter real gain = 1 from [0:inf);

	analog begin
		V(p,n) <+ idt(V(cp,cn)) * gain;
   end
endmodule
