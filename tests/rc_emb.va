/* Author: Felix Salfelder 2015
 * Note: too trivial to state License/Copyright
 *
 * Resistor and Cap in series using embedded models
 */

`include "discipline.h"

module myC(p,n);
	inout p,n;
	electrical p,n;

	parameter real c = 1 from [0:inf) (*type="instance"*);
	analog begin
		I(p,n) <+ c*ddt(V(p,n));
   end
endmodule

module myR(p,n);
	inout p,n;
	electrical p,n;

	parameter real r = 100  (*type="instance"*);
	real i (*ask="yes"*);
	real v (*ask="yes"*);
	analog begin
 		I(p,n) <+ V(p,n) / r;
   end
endmodule

module rc(in,out,g);
   inout in,out,g;
   electrical in,out,g;

   parameter real c=1e-6 from [0:inf);
   parameter real r=1e3 from [0:inf);

	myR #(.r(r)) r1 (in,out);
	myC #(.c(c)) c1 (out,g);
endmodule
