`include "disciplines.h"

module CAPACITOR(p,n);

	inout p, n;
	electrical p, n;

	parameter integer C=1 from [0:1] (*info="Capacitor type (not used)"*);

	parameter real l=1.0 (*type="instance" info="Length" unit="m"*);
	parameter real w=2.0 (*ask="yes" type="instance" info="Width" unit="m"*);
	parameter real test=1.0 (*info="dummy" unit="m"*);

	analog function real capacitance;
		input W;
		real W;
		input L;
		real L;
		begin
			capacitance = W * L;
		end
	endfunction
	real v;

	analog begin
		real Cap;
		v = V(p,n);

		Cap=capacitance(w, l);

		I(p, n) <+ Cap*ddt(V(p, n));
	end
endmodule

module CAPACITOR2(p,n);

	inout p, n;
	electrical p, n;

	parameter integer C=1 from [0:1] (*info="Capacitor type (not used)"*);

	parameter real l=1.0 (*type="instance" info="Length" unit="m"*);
	parameter real w=2.0 (*ask="yes" type="instance" info="Width" unit="m"*);
	parameter real test=1.0 (*info="dummy" unit="m"*);

	analog function real capacitance;
		input W;
		input L;
		input X;

		real W;
		real L;
		begin
			capacitance = W * L * X;
		end
	endfunction
	real v;

	analog begin
		real Cap;
		v = V(p,n);

		Cap=capacitance(w, l, ddt(V(p, n)));

		I(p, n) <+ Cap*2;
	end
endmodule
