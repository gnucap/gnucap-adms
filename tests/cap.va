// Copyright 2013 Felix
// voltage source

`include "discipline.h"
`include "constants.h"

module va_cap(p,n);
	inout p,n;
	electrical p,n;

	parameter real capacitance    = 1 from [0:inf);

	analog begin
		I(p,n) <+ capacitance*ddt(V(p,n));
   end
endmodule
