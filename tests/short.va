// Copyright 2015 Felix Salfelder
// short circuit

`include "discipline.h"
`include "constants.h"

module short1(p,n);
	inout p,n;
	electrical p,n;

	real i (*ask="yes"*);
	analog begin
 		i = I(p,n);
   end
endmodule

module short2(p,n);
	inout p,n;
	electrical p,n;

	analog begin
 		V(p,n) <+ 0.;
   end
endmodule
