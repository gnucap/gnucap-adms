// Copyright 2013 Felix
// current sources

`include "discipline.h"
`include "constants.h"

module vavccs(p,n,cp,cn);
	inout p,n,cp,cn;
	electrical p,n,cp,cn;

   parameter real gain    = 1 from [0:inf);

   real loss;
   analog begin
      I(p,n) <+ gain*V(cp,cn);
   end
endmodule
