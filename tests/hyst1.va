`include "discipline.h"
`include "constants.h"

// hysteresis device. inspired by Olafs mos-ak talk
module hyst1(pix, top, gnd, dir, pol, drv);
	inout pix, top, gnd, dir, pol, drv;
	electrical pix, top, gnd, dir, pol, drv; // BUG

   parameter real cgr   = 6.5k from (0:inf); // [Ohm*m*m]
   parameter real ps    = 2.5e-2 from (0:inf); // [C/m/m]
   parameter real dpix  = 1e-3 from (0:inf); // pixel pitch [m]
   parameter real v0    = 1.0 from (0:inf);
   parameter real vc    = 3.0 from (0:inf);
	real p;
	real u;
	real v;
	real w;
	real c_ (*ask="yes"*);

   analog begin
		v = V(pix, top);

		I(drv, gnd) <+ ddt(v);
		I(drv, gnd) <+ -V(drv, gnd);

		u = V(drv, gnd);

		w = tanh(u*1e9);
		I(dir, gnd) <+ w - V(dir, gnd);
		real c_up;
		real c_dn;
		// real c_; // BUG
		real f_up;
		real f_dn;
		real dp_up;
		real dp_dn;
		real dp_dv;
		f_up = 1.0 / (1.0 + limexp(( vc - v )/v0 )) / v0;
		f_dn = 1.0 / (1.0 + limexp(( vc + v )/v0 )) / v0;

		p = V(pol, gnd);

		dp_dn = p*f_dn;
		dp_up = (1.0-p)*f_up;
		dp_dv = .5 * (dp_up + dp_dn) + .5 * ( dp_up - dp_dn )*w;

		I(pol, gnd) <+ dp_dv*u;
		I(pol, gnd) <+ -ddt(p);
		c_up = 2.0 * ps * ( 1.0 - p) * f_up;
		c_dn = 2.0 * ps * p * f_dn;
		if (w == 0 )
			c_ = .5 * (c_up + c_dn); // BUG
		else
			c_ = .5 * (c_up + c_dn) + .5 * (c_up - c_dn) * w;

		I(pix, top) <+ dpix * dpix * c_ * u;
		I(pix, top) <+ dpix * dpix * v / cgr;

   end
endmodule
