// Copyright 2015 Felix
// cap with ddt arg rescale.

// rescaling somehow affects step control...

`include "discipline.h"
`include "constants.h"

module va_cap(p,n);
	inout p,n;
	electrical p,n;

	parameter real capacitance = 1 from [0:inf);
	parameter real rescale = 1 from [0:inf);

	analog begin
		real dd;
		dd = ddt(rescale*V(p,n))/rescale;
		I(p,n) <+ capacitance*dd;
   end
endmodule
