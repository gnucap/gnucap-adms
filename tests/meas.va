// Copyright 2015 Felix Salfelder
// meas test

`include "discipline.h"
`include "constants.h"
`define P(x) (*x*)

module measv(p,n);
	inout p,n;
	electrical p,n;

	real v `P(ask="yes");
	analog begin
		v = V(p,n);
   end
endmodule

module measi(p,n);
	inout p,n;
	electrical p,n;

	real i `P(ask="yes");
	analog begin
		i = I(p,n);
   end
endmodule
