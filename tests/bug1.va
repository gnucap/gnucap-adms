/* Authors: Felix Salfelder
 * Note: too trivial to state License/Copyright
 *
 * variables declared in analog block (BUG)
 */
`define P(x) (*x*)
`include "discipline.h"

module dif (p,n);
	inout p,n;
	electrical p,n;

	parameter real r=1 from (0:inf)
	                `P(info="Resistor [Ohm]");

	analog begin
	real BUGg; // BUG this variable will not be expanded correctly
	real current;
		@(initial_model) begin
			BUGg = 1/r;
		end
		current = 0;
		$strobe("hello");
		if(BUGg>0) begin
			$strobe(" world %f", BUGg);
			current = V(p,n)*BUGg;
		end
		$strobe("\n");
		I(p,n) <+ current;
	end
endmodule
