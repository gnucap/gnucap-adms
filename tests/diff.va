/* this file is part of gnucap-adms
 *
 * Author: (c) 2013 Felix Salfelder
 * License: GPLv3+
 */

// diff

`include "disciplines.vams"
`include "constants.vams"

module diff(p,n,cp,cn);
	inout p,n,cp,cn;
	electrical p,n,cp,cn;

	parameter real gain = 1 from [0:inf);

	analog begin
		V(p,n) <+ ddt(V(cp,cn) * gain); //  - 1e-10*V(p,n));
   end
endmodule
