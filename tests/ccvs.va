// Copyright 2013 Felix
// voltage sources

`include "discipline.h"
`include "constants.h"

module ccvsva(p,n,cp,cn);
	inout p,n,cp,cn;
	electrical p,n,cp,cn;

	parameter real gain    = 1 from [0:inf);
	parameter real offset  = 0;

	real i (*ask="yes"*);
	analog begin
		i = I(cp,cn);
		V(p,n) <+ gain * i + offset;
   end
endmodule
