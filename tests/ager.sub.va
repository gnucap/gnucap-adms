// 'aging' resistor. dataflow demonstrator

`include "discipline.h"
`include "gnucap-adms.h"

`ifdef insideADMS
 `define P(p) (*p*)
`else
 `define
`endif

module ageQ(p, n, d);
   parameter real dummy=0. `P(type="instance");  // BUG.
   electrical p,n;
	real a `P(ask="yes");
	real b `P(ask="yes");
	degradational d;
	degradational d1;
	degradational d2;
	rcd_exp #(.weight(1.), .re0(4), .re1(3), .rc0(5), .rc1(-2)) rcd1(p,n,d1);
	rcd_exp #(.weight(1.1), .re0(4), .re1(3), .rc0(5), .rc1(-2)) rcd2(p,n,d2);

	analog begin
		a = State(d1) + 0.9998 * State(d2);
		State(d) <+ State(d1) + 0.999 * State(d2);
		b = State(d);
	end
endmodule

module ager(p,n);
   inout p,n;
   electrical p,n;
	degradational nage;

   // Model parameters
   parameter real r0=10000 from (0:inf)
                  (*info="Fresh resistance [Ohm]"*);

   real v1, i1, g;
	real a `P(ask="yes");
	real b `P(ask="yes");

	ageQ #(.dummy(0)) myQ(p,n,nage);

   analog begin
		@(initial_model) begin
			g=1/r0;
		end
		@(initial_instance) begin
			a=0;
		end
		@(initial_step) begin
			b = State(nage);
		end

      begin
			a = State(nage);
		   v1 = V(p,n);
         i1 = v1*g/(1+a);
         I(p,n) <+ i1;
      end
   end
endmodule
