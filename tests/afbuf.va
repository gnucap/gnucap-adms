`include "disciplines.h"

module afbuf(p,n,cp,cn);
	inout p,n,cp,cn;
	electrical p,n,cp,cn;

	analog function real diff;
		input x;
		input y;
		begin
			diff = x - y;
		end
	endfunction
   analog begin
      V(p,n) <+ diff(V(cp),V(cn));
   end
endmodule
