/* Authors: Andreas Froese, Felix Salfelder
 * Note: too trivial to state License/Copyright
 *
 * test if statement and related guesstopology stuff
 */
`define P(x) (*x*)
`include "discipline.h"

module dif (p,n);
	inout p,n;
	electrical p,n;

	parameter real r=1 from (0:inf)
	                `P(info="Resistor [Ohm]");

	real g;
	real current;
	analog begin
		@(initial_model) begin
			g=1/r;
		end
		current = 0;
		if(g>0) begin
			current = V(p,n)*g;
			I(p,n) <+ current;
		end
	end
endmodule
