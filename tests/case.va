// Copyright 2015 Felix Salfelder
//
// for loop

`include "discipline.h"
`include "constants.h"

module vscase(p,n);
	inout p,n;
	electrical p,n;

	parameter real voltage = 1 from [0:inf);
	parameter integer selectx  = 0 from [0:inf);

	analog begin
		integer s; s = selectx; // BUG
		case(s)
			0, 2, 4: V(p,n) <+ voltage;
			1, 3, 5: V(p,n) <+ -voltage;
			default: V(p,n) <+ 0.;
		endcase
   end
endmodule
