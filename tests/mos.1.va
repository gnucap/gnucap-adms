`include "discipline.h"
`include "constants.h"
`include "gnucap-adms.h"

// level1 mosfet with symmetric bti effect

`define pN 1
`define pP 0

`define EPS0   8.8541879239442001396789635e-12
`define EPS_OX 3.9*`EPS0/100.0

`ifdef insideADMS
 `define P(p) (*p*)
`else
 `define
`endif

module ageQ(p, n, d);
   parameter real dummy=0. `P(type="instance");  // BUG.
   electrical p,n;
	real a `P(ask="yes");
	real b `P(ask="yes");
	degradational d;
	degradational d1;
	degradational d2;
	rcd_exp #(.weight(1.), .re0(4), .re1(3), .rc0(5), .rc1(-2)) rcd1(p,n,d1);
	rcd_exp #(.weight(1.1), .re0(4), .re1(3), .rc0(5), .rc1(-2)) rcd2(p,n,d2);

	analog begin
		@ ( initial_step ) begin
			State(d) <+ 0;
		end
		a = State(d1) + 0.9998 * State(d2);
		State(d) <+ State(d1) + 0.999 * State(d2);
		b = State(d);
	end
endmodule

// rcd_exp #(.weight(1.0),.rc1( -0.918575143488 ),.rc0( 2.80018441431 ),.re1( 15 ),.re0( -7.20755460708 )) rcd1(p,n,n1);
// rcd_exp #(.weight(1.0),.rc1( -2.64228467952 ),.rc0( 12.2765264147 ),.re1( 9.07117840498e-05 ),.re0( 14.6707252045 )) rcd2(p,n,n2);
// rcd_exp #(.weight(1.0),.rc1( -2.4247482313 ),.rc0( 1.08537938238 ),.re1( 14.6182408203 ),.re0( -13.9958348352 )) rcd3(p,n,n3);
// rcd_exp #(.weight(1.0),.rc1( -3.19813500452 ),.rc0( 6.19542727471 ),.re1( 0.90495810843 ),.re0( 7.20516736064 )) rcd4(p,n,n4);
// rcd_exp #(.weight(1.0),.rc1( -1.92364339752 ),.rc0( 14.6552926276 ),.re1( 0.000190581469863 ),.re0( 13.3081719097 )) rcd5(p,n,n5);
// rcd_exp #(.weight(1.0),.rc1( -7.98425840979 ),.rc0( -0.269774814501 ),.re1( 6.44762414576 ),.re0( 1.16250648537 )) rcd6(p,n,n6);
// rcd_exp #(.weight(1.0),.rc1( -4.40239992649 ),.rc0( 2.15401140064 ),.re1( 0.701442804259 ),.re0( 3.36311990132 )) rcd7(p,n,n7);
// rcd_exp #(.weight(1.0),.rc1( -15 ),.rc0( -12.2945766773 ),.re1( 0 ),.re0( -12.4247024171 )) rcd8(p,n,n8);
// rcd_exp #(.weight(1.0),.rc1( -11.8337209927 ),.rc0( -7.02993934662 ),.re1( 10.4264405622 ),.re0( -6.62709211598 )) rcd9(p,n,n9);
// rcd_exp #(.weight(1.0),.rc1( -10.4968133834 ),.rc0( -12.1745579822 ),.re1( 14.5519052045 ),.re0( -14.4936645809 )) rcd10(p,n,n10);
// rcd_exp #(.weight(1.0),.rc1( -11.9728221279 ),.rc0( 7.69020588138 ),.re1( 3.0904916348 ),.re0( 10.2800471825 )) rcd11(p,n,n11);
// rcd_exp #(.weight(1.0),.rc1( -2.72355519781 ),.rc0( 9.42745638551 ),.re1( 0 ),.re0( 9.56665329482 )) rcd12(p,n,n12);
// rcd_exp #(.weight(1.0),.rc1( -15 ),.rc0( -1.16657723294 ),.re1( 5.36743281295 ),.re0( 0.492019713577 )) rcd13(p,n,n13);
// rcd_exp #(.weight(1.0),.rc1( -7.20174074178 ),.rc0( -11.1572221107 ),.re1( 6.0301379906 ),.re0( -10.213238751 )) rcd14(p,n,n14);
// a=0+ 0.00226946484451 * State(n1 )+ 0.599453575547 * State(n2 )+ 0.00153403159351 * State(n3 )+ 0.0409176658873 * State(n4 )+ 0.21901824831 * State(n5 )+ 0.00207923161729 * State(n6 )+ 0.0145566664969 * State(n7 )+ 0.0105703696787 * State(n8 )+ 0.000249444148959 * State(n9 )+ -1.22749888299e-08 * State(n10 )+ -5.10672928128e-09 * State(n11 )+ 0.0568658855838 * State(n12 )+ 0.00107645586561 * State(n13 )+ 4.45056694428e-09 * State(n14 );

//--------------------
// mos_level1
//
// -  A basic, level 1, Schichmann-Hodges style model of a MOSFET transistor
//
// INSTANCE parameters
//    width  = [m]
//    length = [m]
//    vto    = threshold voltage [V]
//    gamma  = bulk threshold []
//    phi    = bulk junction potential [V]
//    lambda = channel length modulation []
//    tox    = oxide thickness []
//    u0     = transconductance factor []
//    xj     = metallurgical junction depth []
//    is     = saturation current []
//    cj     = bulk junction capacitance [F]
//    vj     = bulk junction voltage [V]
//    mj     = bulk grading coefficient []
//    fc     = forward bias capacitance factor []
//    tau    = parasitic diode factor []
//    cgbo   = gate-bulk overlap capacitance [F]
//    cgso   = gate-source overlap capacitance [F]
//    cgdo   = gate-drain overlap capacitance [F]
//    dev_type   = the type of mosfet used []
//

// currently: pmos only.
// only forward polarity...
module mos_level1(drain, gate, source, bulk);
	inout drain, gate, source, bulk;
	electrical drain, gate, source, bulk;
	electrical mid;
	degradational deg0, deg1, deg2;

	parameter real width = 1u    from (0:inf);
	parameter real length = 1u   from (0:inf);
	parameter real vto = 1       from (0:inf);
	parameter real gamma = 0     from [0:inf);
	parameter real phi = 0.6     from (0:inf);
	parameter real lambda = 0.05 from [0:inf);
	parameter real tox = 1e-7    from (0:inf);
	parameter real u0 = 600      from (0:inf);
	parameter real xj = 0        from [0:inf);
	parameter real is = 1e-14    from (0:inf);
	parameter real cj=0          from [0:inf);
	parameter real vj=0.75       exclude 0;
	parameter real mj=0.5        from [0:1);
	parameter real fc=0.5        from [0:1);
	parameter real tau = 0       from [0:inf);
	parameter real cgbo = 0      from [0:inf);
	parameter real cgso = 0      from [0:inf);
	parameter real cgdo = 0      from [0:inf);
	parameter integer dev_type = `pN;

`define F1(m, f, v)     ((v/(1 - m))*(1 - pow((1 - f), m)))
`define F2(m, f)        (pow((1 - f), (1 + m)))
`define F3(m, f)        (1 - f*(1 + m))

	real vds,
	     vgs,
	     vbs,
	     vbd,
	     vgb,
	     vgd,
	     vth,
	     id,
	     ibs,
	     ibd,
	     qgb,
	     qgs,
	     qgd,
	     qbd,
	     qbs;
	real dvth_d (* ask="yes" *);
	real dvth_s (* ask="yes" *);
	real dvth_eff (* ask="yes" *);
	real dvth_avg (* ask="yes" *);
	real dvth0 (* ask="yes" *);
	real dvth1 (* ask="yes" *);
	real dvth2 (* ask="yes" *);

	real kp, fc1, fc2, fc3, fpb, leff;
	real beta;

	integer dev_type_sign;

	analog function real carriers;
		input vgs;
		input vgd;
		input vth;
		begin
//			real vds; BUG
//			vds = vgs - vgd;
			if (vgs <= vth) begin
				carriers = 0.;
			end else if (vgd > vth ) begin
				//
				// linear region.
				//
				carriers = (vgs - vth - (vgs-vgd)/2);
			end else begin
				//
				// saturation region.
				//
				carriers = 0.5*(vgs - vth)*(vgs - vth) / (vgs-vgd);
			end
		end
	endfunction

	ageQ #(.dummy(0)) myQ0(source,gate,deg0);
	ageQ #(.dummy(0)) myQ1(mid,gate,deg1);
	ageQ #(.dummy(0)) myQ2(drain,gate,deg2);

	analog begin
		// initial_model?!
		@ ( initial_step ) begin
			leff = length - 2*xj;
			kp = u0*`EPS_OX/tox;
			fc1 = `F1(mj, fc, vj);
			fc2 = `F2(mj, fc);
			fc3 = `F3(mj, fc);
			fpb = fc*mj;
			dvth_eff = 0.;

			if( dev_type == `pN )
				dev_type_sign = 1;
			else
				dev_type_sign = -1;
		end

		vds = dev_type_sign*V(drain, source);
		vgs = dev_type_sign*V(gate, source);
		vgb = dev_type_sign*V(gate, bulk);
		vgd = dev_type_sign*V(gate, drain);
		vbs = dev_type_sign*V(bulk, source);
		vbd = dev_type_sign*V(bulk, drain);

		// if (vds < 0) begin
		// 	reversed = !reversed;
		// 	vgs -= vds;
		// 	vbs -= vds;
		// 	vds = -vds;
		// end

		V(mid) <+ (V(drain) + V(gate)) *.5;

		if (vbs > 2*phi) begin
			vth = vto + gamma*sqrt(2*phi);
		end else begin
			vth = vto + gamma*(sqrt(2*phi) - sqrt(2*phi - vbs));
		end

// --------------------------

		//
		// parasitic diodes...
		//
		ibd = is*(exp(vbd/$vt) - 1);
		ibs = is*(exp(vbs/$vt) - 1);

		if (vbd <= fpb) begin
			qbd = tau*ibd + cj*vj*(1 - pow((1 - vbd/vj), (1 - mj)))/(1 - mj);
		end else begin
			qbd = tau*ibd + cj*(fc1 + (1/fc2)*(fc3*(vbd - fpb) +
			      (0.5*mj/vj)*(vbd*vbd - fpb*fpb)));
		end

		if (vbs <= fpb) begin
			qbs = tau*ibs + cj*vj*(1 - pow((1 - vbs/vj), (1 - mj)))/(1 - mj);
		end else begin
			qbs = tau*ibs + cj*(fc1 + (1/fc2)*(fc3*(vbs - fpb) +
			      (0.5*mj/vj)*(vbs*vbs - fpb*fpb)));
		end

		//
		// channel component of drain current. (channel charge ignored)...
		//
		real gd_raw; gd_raw = 0;
		beta = kp*width/leff;
		vgd = vgs - vds;

		dvth0 = State(deg0);
		dvth1 = State(deg1);
		dvth2 = State(deg2);

		real vg0; vg0 = vgs;
		real vg1; vg1 = (2.*vgs + vgd)/3.;
		real vg2; vg2 = (vgs + 2.*vgd)/3.;
		real vg3; vg3 = vgd;

		gd_raw = gd_raw + carriers(vg0, vg1, vth+dvth0) / 3.;
		gd_raw = gd_raw + carriers(vg1, vg2, vth+dvth1) / 3.;
		gd_raw = gd_raw + carriers(vg2, vg3, vth+dvth2) / 3.;

		real gd;
		gd = gd_raw * beta * (1 + lambda*vds);

		qgb = cgbo * vgb;
		qgs = cgso * vgs;
		qgd = cgdo * vgd;

		I(drain, source) <+ dev_type_sign *  gd * vds;
		I(bulk, drain)   <+ dev_type_sign * (ibd + ddt(qbd));
		I(bulk, source)  <+ dev_type_sign * (ibs + ddt(qbs));
		I(gate, bulk)    <+ dev_type_sign *  ddt(qgb);
		I(gate, source)  <+ dev_type_sign *  ddt(qgs);
		I(gate, drain)   <+ dev_type_sign *  ddt(qgd);
	end
endmodule
