// Copyright 2015 Felix Salfelder
//
// voltage source source grouping

`include "discipline.h"
`include "constants.h"

module vsgroup(p,n);
	inout p,n;
	electrical p,n;

	parameter real voltage    = 1 from [0:inf);

	real loss;
	analog begin
		V(p,n) <+ voltage/2;
		V(p,n) <+ voltage/4;
		V(p,n) <+ voltage/8;
   end
endmodule
