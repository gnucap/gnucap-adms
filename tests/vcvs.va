// Copyright 2013 Felix
// current sources

`include "discipline.h"
`include "constants.h"

module vavcvs(p,n,cp,cn);
	inout p,n,cp,cn;
	electrical p,n,cp,cn;

   parameter real gain    = 1 from [0:inf);

   real loss;
   analog begin
      V(p,n) <+ gain*V(cp,cn);
      I(p,n) <+ 0*V(cp,cn); // BUG
   end
endmodule
