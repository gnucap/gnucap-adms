`include "gnucap-adms.h"
`include "discipline.h"

module subcoil(p,n);
   inout p,n;
   electrical p,n;

   // Model parameters
   parameter real r0=10000 from (0:inf)
                  (*info="Fresh resistance [Ohm]"*);

   real v1, i1, g;
	real a (*ask="yes"*);
	real b (*ask="yes"*);

	L #(.l(1)) l1(p,n);

   analog begin

   end
endmodule
