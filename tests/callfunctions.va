`define P(x) (*x*)
`include "discipline.h"

module callfunctions (p,n);
   inout p,n;
   electrical p,n;

   analog begin
		if(V(p)<V(n))
			$warning("negative %f", V(p)-V(n));
		if(V(p)>V(n))
			$strobe("positive %f", V(p)-V(n));
		if(V(p)-V(n)<-.9)
			$error("too negative %f", V(p)-V(n));
   end
endmodule
