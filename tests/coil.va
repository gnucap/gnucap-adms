//
// coil variants

`include "discipline.h"
`include "constants.h"

module coil_mag(p1,p2);
	inout p1,p2;
	electrical p1,p2;
	magnetic m1;

	parameter real inductance = 1.0e-3;

	branch (p1,p2) res;
	real v (*ask="yes"*);

	analog begin
		v = V(res);
		Phi(m1) <+ ddt(MMF(m1));
		Phi(m1) <+ - inductance * V(res);
		I(res) <+ MMF(m1);
	end
endmodule

// does not converge well
module coil_br(p,n);
	inout p,n;
	electrical p,n;
	electrical e1;

	parameter real inductance = 1;
	real i (*ask="yes"*);
	real v (*ask="yes"*);

	analog begin
		i = I(e1,n);
		v = ddt(inductance * I(e1,n));
		V(p,e1) <+ ddt(inductance * I(e1,n));
	//	I(p) <+ 0*V(n); // BUG
	end
endmodule

module coil_idt(p,n);
	inout p,n;
	electrical p,n;

	parameter real inductance    = 1 from [0:inf);

	analog begin
		I(p,n) <+ idt(V(p,n)/inductance);
   end
endmodule

`ifdef foo

// this cannot work, a flow probe shortcuts the potential
module coil_auto(p,n);
	inout p,n;
	electrical p,n;

	parameter real inductance    = 1 from [0:inf);

	analog begin
		V(p,n) <+ ddt(inductance * I(p,n));
   end
endmodule

module coilideal(p,n);
	inout p,n;
	electrical p,n;
	electrical q;

	parameter real inductance    = 1 from [0:inf);

	real loss;
	analog begin
		I(q) <+ inductance - V(p,n);
		I(p,n) <+ V(q);
   end
endmodule

module coilreal(p,n);
	inout p,n;
	electrical p,n;

	parameter real inductance    = 1 from [0:inf);
	parameter real loss       = 1e9 from [0:inf);

	real i (*ask="yes"*);

	analog begin
		i = (V(p,n)-inductance)*loss;
		I(p,n) <+ i;
   end
endmodule
`endif
