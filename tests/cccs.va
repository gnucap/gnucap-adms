// Copyright 2015 Felix
// cccs

`include "discipline.h"
`include "constants.h"

module cccsva(p,n,cp,cn);
	inout p,n,cp,cn;
	electrical p,n,cp,cn;

	parameter real gain    = 2 from [0:inf);
	parameter real offset  = 0;

	real i (*ask="yes"*);
	analog begin
		I(p,n) <+ gain * I(cp,cn) + offset;
//		I(p,n) <+ 0 * V(cp,cn); // top bug
	end
endmodule

`ifdef notyet
module prbtest(p,n,cp,cn);
	inout p,n,cp,cn;
	electrical p,n,cp,cn;

	electrical t1, t2;

	analog begin
		I(p,n) <+ I(cp,cn);
		I(t1,t2) <+ I(p,n);
	end
endmodule
`endif
