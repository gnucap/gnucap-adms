/* this file is part of gnucap-adms
 *
 * Author: (c) 2018 Felix Salfelder
 * License: GPLv3+
 */

// sin

`include "discipline.h"
`include "constants.h"

module sin_(out, in);
	inout out, in;
	electrical out, in;

	parameter real phase = 0 from (-inf:inf);
	parameter real amplitude = 1 from (-inf:inf);
	parameter real igain = 1 from (-inf:inf);

	analog begin
      // incomplete: there is no cross event
		V(out) <+ amplitude * sin(igain*V(in)+phase);
   end
endmodule
