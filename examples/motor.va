// Copyright: 2013 Andreas F"urtig, Felix Salfelder
// License: GPLv3+

// a motor

`include "discipline.h"
`include "constants.h"

module motor(p1,p2,sens);
	inout p1,p2,sens;
	electrical p1,p2,sens;
	rotational_omega t1;

	parameter real R_fric     = 1.0e-8,
	               R_inertia  = 1.0e-12,
	               Alpha      = 3.0e-3,
	               Rnom       = 50.0 from (0:inf);

	real reff      (*ask="yes"*);
	real omega     (*ask="yes"*);
	real P_el      (*ask="yes"*);
	real P_rot     (*ask="yes"*);
	real P_fric    (*ask="yes"*);
	real I         (*ask="yes"*);
	real t4;
	branch (p1,p2) res;

	analog begin
		I = I(res);
		reff = - Rnom*(Omega(t1));

		P_fric = R_fric * Omega(t1);
		P_rot = R_inertia * ddt(Omega(t1));

		I(res) <+ - Omega(t1) * R_fric;
		I(res) <+ V(res)/100;
		Tau(t1) <+ - I(res)  +0*V(res);
		Tau(t1) <+ - P_fric;
		Tau(t1) <+ - ddt(R_inertia * Omega(t1)); // BUG (see BUGS)
		omega = Omega(t1);

		V(sens) <+ Omega(t1)/500;
		I(sens) <+ 0*Omega(t1) + 0*V(sens); // guesstopology hack
   end
endmodule
