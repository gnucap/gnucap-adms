// Copyright: 2013 Andreas F"urtig, Felix Salfelder
// License: GPLv3+

// a motor

`include "discipline.h"
`include "constants.h"
`include "gnucap-adms.h"

module motor(p1,p3,sens);
	inout p1,p3,sens;
	electrical p1,p2,p3,sens;
	rotational_omega t1;

	parameter real R_fric     = 1.0e-8,
	               R_inertia  = 1,
	               Alpha      = 3.0e-3,
	               Rnom       = 50.0 from (0:inf),
	               k_m        = 1.0e-3,
	               r_m        = 1;

	real reff      (*ask="yes"*);
	real omega     (*ask="yes"*);
	real ambient   (*ask="yes"*);
	real P_el      (*ask="yes"*);
	real P_rot     (*ask="yes"*);
	real P_fric    (*ask="yes"*);
	real I         (*ask="yes"*);
	real t4;
	branch (p1,p2) res;

	// coil added between motor and output
	L #(.l(1.0e-6)) l1(p3,p2);

	analog begin
		//reff = Rnom*(1+Alpha*(Omega(t1)-(`P_CELSIUS0+RnomReftemp)));
		I = I(res);
		reff = - Rnom*(Omega(t1));

		P_fric = R_fric * Omega(t1);
		P_rot = R_inertia * ddt(Omega(t1));
		P_el  = V(p1,p2)*I;

		I(res) <+ (V(res) - Omega(t1) * k_m) / r_m;
		Tau(t1) <+ - I(res)  + 0*V(res);
		Tau(t1) <+ - P_fric;
		Tau(t1) <+ - ddt(R_inertia*Omega(t1)); // BUG (see BUGS)
		omega = Omega(t1);

		V(sens) <+ Omega(t1)/500;
		I(sens) <+ 0*Omega(t1); // BUG
   end
endmodule
