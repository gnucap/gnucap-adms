// heatball

`include "discipline.h"
`include "constants.h"

module heatball(p1,p2);
	inout p1,p2;
	electrical p1,p2;
	thermal t1;

	parameter real C_rad      = 1.0e-4,
	               C_tempcap  = 1.0e-12,
	               Alpha      = 3.0e-3,
	               Rnom       = 50.0 from (0:inf),
	               RnomReftemp= 27 from [-`P_CELSIUS0:inf);

	real reff      (*ask="yes"*);
	real temp      (*ask="yes"*);
	real ambient   (*ask="yes"*);
	real P_el      (*ask="yes"*);
	real P_rad     (*ask="yes"*);
	real P_thc     (*ask="yes"*);
	real t4;
	branch (p1,p2) res;

	analog begin
		reff = Rnom*(1+Alpha*(Temp(t1)-(`P_CELSIUS0+RnomReftemp)));

		P_el = V(res)*V(res) / reff;
		t4 = pow($temperature,4);
		P_rad = C_rad * (pow(Temp(t1),4) - t4);
//		P_thc = C_tempcap * ddt(Temp(t1));

		I(res) <+ V(res) / reff;
		// Pwr(t1) <+ P_el - P_rad - P_thc;
		Pwr(t1) <+ P_el; // V(res)*V(res) / reff; // P_el;
		Pwr(t1) <+ - P_rad;
      Pwr(t1) <+ - ddt(C_tempcap*Temp(t1)); // BUG (see BUGS)
		temp = Temp(t1);
		ambient = $temperature; // tested.
   end
endmodule
