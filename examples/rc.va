/* Author: Felix Salfelder 2012
 * Note: too trivial to state License/Copyright
 *
 * Resistor and Cap in series
 */

`include "discipline.h"
`include "gnucap-adms.h"

module rc(in,out,g);
   inout in,out,g;
   electrical in,out,g;

   parameter real c=1e-6 from [0:inf);
   parameter real r=1e3 from [0:inf);

	R #(.r(r)) r1 (in,out);
	C #(.c(c)) c1 (out,g);

endmodule
