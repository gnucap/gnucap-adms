`include "discipline.h"
`include "constants.h"

module vbg(vbg, bvbg, vdd, vss);
	inout  vbg, bvbg, vdd, vss;
	electrical vbg, bvbg, vdd, vss;

	parameter real psrr = 0.008;  // 1.2493V-1.2485V / 5.5V-4.5V = 0.008
	parameter real rout = 994;    // 1.244V-1.052V /200uA-7uA = 994 Ohm
	// < 10uA
	parameter real routb = 2E3;
	parameter real C1 = 1E-9;
	parameter real Ibias = 44E-6;
	parameter real bg = 1.249;    // bandgap voltage
	// temparature
	parameter real vbias = 0.6408;
	parameter real Imax = 100E-6; // Maximaler Ausgangsstrom
	parameter real Vddmin = 2.34; // Miniale Versorgungsspannung

	real i_out (*ask="yes"*);
	real bloed;

	analog begin
		i_out= ( bg - V(vbg, vss) ) /rout  + psrr*(V(vdd,vss)-Vddmin)/rout;
		if ( V(vdd,vss) < 2.0 ) $strobe("vbg.va: Error vbg: Input voltage to low");

//		if ( i_out > Imax ) i_out=i_out/5+Imax;
//		if ( i_out < -Imax ) i_out=i_out/5-Imax;
//		if ( i_out > Imax ) i_out=+ (i_out-Imax)/Imax*( +0.8*( bg - V(vbg, vss) ) /rout   + 50*psrr*(V(vdd,vss)-Vddmin)/rout);
//		if ( i_out < -Imax ) i_out=+ (-i_out-Imax)/Imax*1.0*(+0.8*( bg - V(vbg, vss) ) /rout + 50*psrr*(V(vdd,vss)-Vddmin)/rout);
		I(vdd, vss) <+ Ibias;
		I(vbg, vss) <+ -i_out;

//		I(vbg, vss) <+ C1 *ddt(V(vbg, vss) );
		I(bvbg, vss) <+ ( vbias - V(bvbg, vss))/routb;
	end
endmodule
