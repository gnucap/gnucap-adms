`include "discipline.h"

module ldo(vbg, vro, vrs, vdd, vss);
	inout  vbg, vro, vrs, vdd, vss;
	electrical vbg, vro, vrs , vdd, vss;

	// vbg: Input : Bandgap voltage
	// vdd = vc2: Input: Supply voltage
	// vro: Output: regulated voltage
	// vrs: Input: to switch Output voltage
	// vss: gnd
	parameter real psrr = 0.0003;    // 1.9195V -1.9198V / 5.5V-4.5V = 0.0003
	parameter real rout = 2;         // 1.9199V - 1.9196V / 153uA-3uA = 2 Ohm
	// < 10uA
	parameter real C1 = 1E-9;
	parameter real Ibias = 1.8E-3;   // Ruhestrom
	parameter real fak1 = 1.6;       // Output voltage / input voltage
	                                 //  if  vrs = open (13.2+22)/22
	parameter real fak2 = 4.138;     // Output voltage /inp voltage if vrs = 0
	                                 // (13.2+(22||5,2)) / (22|| 5,2)
	// temperature
	parameter real Imax = 1.82E-3; // Maximal output current, with
	                               // ideal output resistance
	parameter real rdegout = 1E4;  // Degenerated output resistance
	parameter real  Rrs=5.2E3;
	parameter real  Vddmin = 2.1;  // minimum vdd
	parameter real  Vdrop = 0.3;   // Minimum Drop-Voltage from low drop regulator

	real i_out (*ask="yes"*);
	real u_out (*ask="yes"*);
	real fak ;

	analog begin
		I(vrs, vss) <+ (V(vrs,vss)-fak1*V(vbg,vss))/Rrs;

		if ( V(vrs,vss) < 0.1 )
			fak = fak2;
		else
			fak = fak1;

		u_out = fak * V(vbg, vss);
		i_out = ( V(vro,vss) - u_out ) /rout  - psrr*(V(vdd,vss)-Vddmin)/rout;

		if (i_out < -1*   Imax )
			i_out = -0.89*Imax + 0.70*(V(vro,vss)-u_out) /rdegout  - 2500*psrr*(V(vdd,vss)-Vddmin)/rdegout;

		I(vro, vss) <+  i_out;

//		if ( (V(vdd)-V(vro)) < Vdrop ) $strobe("Vdrop too small");
//		I(vbg, vss) <+ C1 *ddt(V(vbg, vss) );
//		output current at output bvbg

	end
endmodule
