// Copyright: Andreas Froese, 2012
// License: GPLv3+

// oparational amplifier
// based on example from Vlach/Singhal:
// "Computer Methods for Circuit Analysis and Design"

`include "discipline.h"
`include "constants.h"

module opamp(out, inp, inn, vddp, vddn, vref);
	inout      out, vref, inp, inn, vddp, vddn;
	electrical out, vref, inp, inn, vddp, vddn;

	// parameter
	parameter real A0   = 2e5;
	parameter real Rin  = 2e6;
	parameter real Rinp = 2000e6;
	parameter real Rinn = 2000e6;
	parameter real Rout = 75;
	parameter real Sr   = 5e5;
	parameter real f0dB = 1e6;

	// internal
	parameter r1 = 100e6;
	parameter Rf = 10;

	// precalculated
	real c1 (*ask="yes"*);
	real g1 (*ask="yes"*);
	real g2 (*ask="yes"*);
	real Im (*ask="yes"*);
	real Vk (*ask="yes"*);
	real w0 (*ask="yes"*);
	real w1 (*ask="yes"*);

	// variables
	real i_unlim (*ask="yes"*);
	electrical v1;

	analog begin
		@ initial_model begin
			w0 = `M_TWO_PI * f0dB;
			w1 = w0 / A0;
			c1 = 1 / (w1*r1);	// w1 = 1/(c1*r1)
			g2 = 1 / Rout;
			g1 = A0 / r1;		// A0 = g1 * r1 * g2 * Rout
			Im = c1 * Sr;		// |dV/dt| = 1/C * |i| <= Im / C
			Vk = Im / g1;
		end

		// input stage
		I(inp, vref) <+ V(inp, vref) / Rinp;
		I(inn, vref) <+ V(inn, vref) / Rinn;
		I(inp, inn)  <+ V(inp, inn) / Rin;

		// w1
		I(v1, vref) <+ c1 * ddt(V(v1, vref));
		I(v1, vref) <+ V(v1, vref) / r1;

		// slew rate
		i_unlim = g1 * V(inp, inn);
		if( i_unlim > Im ) i_unlim = Im;
		if( i_unlim < -Im ) i_unlim = -Im;
		I(vref, v1) <+ i_unlim;

		// output stage
		I(vref, out) <+ g2 * V(v1, vref);
		I(vref, out) <+ V(vref, out) / Rout;

		// finite output swing
		if( V(v1) > V(vddp) ) I(v1, vref) <+ V(v1, vddp) / Rf;
		if( V(v1) < V(vddn) ) I(v1, vref) <+ V(v1, vddn) / Rf;
	end
endmodule
