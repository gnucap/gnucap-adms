/* Authors: Andreas Froese, Felix Salfelder
 * Note: too trivial to state License/Copyright
 *
 * Capacitor
 */

`define P(x) (*x*)
`include "discipline.h"

module cap(p,n);
   inout p,n;
   electrical p,n;

   parameter real c=1e-6 from [0:inf);
                  `P(info="Capaciance [Coulomb]");
   real i1 `P(ask="yes");

   analog begin
      begin
			i1 = c*ddt(V(p,n));
         I(p,n) <+ i1;
      end
   end
endmodule
